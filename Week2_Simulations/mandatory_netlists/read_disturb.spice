* 6T SRAM Read Disturb Analysis
* Technology: SKY130 | VDD = 1.8V

* UPDATE THIS PATH TO YOUR LOCAL PDK LOCATION
.lib "/usr/local/share/pdk/sky130A/libs.tech/combined/sky130.lib.spice" tt

* --- 6T Bitcell Subcircuit ---
.subckt sram_6t wl bl blb vdd gnd q qb
XM3 q  qb vdd vdd sky130_fd_pr__pfet_01v8 W=0.42 L=0.15 nf=1
XM4 qb q  vdd vdd sky130_fd_pr__pfet_01v8 W=0.42 L=0.15 nf=1
XM1 q  qb gnd gnd sky130_fd_pr__nfet_01v8 W=0.84 L=0.15 nf=1
XM2 qb q  gnd gnd sky130_fd_pr__nfet_01v8 W=0.84 L=0.15 nf=1
XM5 q  wl bl  gnd sky130_fd_pr__nfet_01v8 W=0.42 L=0.15 nf=1
XM6 qb wl blb gnd sky130_fd_pr__nfet_01v8 W=0.42 L=0.15 nf=1
.ends

X1 WL BL BLB VDD GND Q QB sram_6t
Vdd VDD GND DC 1.8

* --- Stimulus (Precharge High, Pulse WL) ---
Vbl BL GND DC 1.8
Vblb BLB GND DC 1.8
Vwl WL GND PULSE(0 1.8 1n 50p 50p 4n 10n)

* --- Initial Condition: Cell holds a '0' ---
.ic V(Q)=0 V(QB)=1.8

* --- Analysis ---
.tran 10p 10n

.control
run
set xbrushwidth=2
plot V(WL) V(Q) V(QB) title "Read Disturb - Notice the bump on node Q"
.endc
.end
