*Precharge Circuit
* Precharge Circuit Simulation
*----------------------------------------------------------

.model PMOS_GEN PMOS (LEVEL=1 VTO=-0.7 KP=40u LAMBDA=0.01)

* Power Supply
VDD     VDD     0     DC 1.8

* Precharge Control Signal (Active Low)
VPRE    PRE_b   0     PULSE(1.8 0 1n 0.1n 0.1n 3n 10n)

* PMOS Precharge Transistors
M1 BL   PRE_b   VDD   VDD   PMOS_GEN W=0.84u L=0.15u
M2 BLB  PRE_b   VDD   VDD   PMOS_GEN W=0.84u L=0.15u

* PMOS Equalizer
M3 BL   PRE_b   BLB   VDD   PMOS_GEN W=0.84u L=0.15u

* Bitline Capacitances
CBL     BL      0     20f
CBLB    BLB     0     20f

* Initial Conditions
.ic V(BL)=0 V(BLB)=0.5

* Analysis
.control
tran 10p 10n
run
plot v(BL) v(BLB) v(PRE_b)
.endc

.end
